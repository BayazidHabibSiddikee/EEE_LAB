Dynamic Circuit: Complex TRIAC and DIAC Circuit
.include "/home/sword/Documents/LAB_Expert/labgen/models/triac.sub"
.include "/home/sword/Documents/LAB_Expert/labgen/models/diac.sub"

* Circuit
V1 1 0 DC 0
R2 2 0 10k
R1 1 4 470
C1 4 0 0.5u
R3 4 3 100
XD1 3 2 DIAC
XT1 1 2 4 TRIAC

* Analysis
.dc V1 -15 15 0.1

.control
    run
    let V_target = V(2)
    let I_target = -I(V1)
    wrdata runs/complex_triac_and_diac_circuit/iv_data_2.txt V_target I_target
.endc
.end
