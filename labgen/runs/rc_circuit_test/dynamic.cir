Dynamic Circuit: RC Circuit Test

* Circuit
V1 1 0 AC 1
R1 1 2 10k
C1 2 0 1uF

* Analysis
.dc V1 -15 15 0.1

.control
    run
    let V_target = V(2)
    let I_target = -I(V1)
    wrdata runs/rc_circuit_test/iv_data_2.txt V_target I_target
.endc
.end
