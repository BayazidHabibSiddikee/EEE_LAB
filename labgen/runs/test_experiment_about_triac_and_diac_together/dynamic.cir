Dynamic Circuit: Test Experiment about triac and diac together
.include "/home/sword/Documents/LAB_Expert/labgen/models/triac.sub"

* Circuit
V1 1 0 AC 120
R1 1 2 470
XT1 2 0 3 DIAC
R2 2 3 100
XT2 4 0 3 TRIAC
RLOAD 4 0 100

* Analysis
.dc V1 -15 15 0.1

.control
    run
    let V_target = V(2)
    let I_target = -I(V1)
    wrdata runs/test_experiment_about_triac_and_diac_together/iv_data.txt V_target I_target
.endc
.end
