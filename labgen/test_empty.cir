* Test
.dc V2 0 1 1
.control
    run
    wrdata test_empty.txt V(2)
.endc
.end
