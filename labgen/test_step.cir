.title Step Test
V1 1 0 DC 10
R1 1 2 {Rvar}
R2 2 0 1k

.param Rvar=1k
.step param Rvar list 1k 5k 10k

.dc V1 0 10 1

.control
    run
    wrdata test_step.txt V(2)
.endc
.end
